.title KiCad schematic
.include "C:/AE/ZXE160/BC807-25.spice.txt"
.include "C:/AE/ZXE160/CEU4J2X7R2A103K125AE_s.mod"
.include "C:/AE/ZXE160/ZXRE160.spice.txt"
.include "C:/AE/ZXE160/c2012x7r1h474k125ab_p.mod"
XU2 /VIN 0 CEU4J2X7R2A103K125AE_s
R4 /VK /VOUT {RK}
R3 /VOUT /VIN {RLIM}
XU1 0 0 /VIN /FB /VK ZXRE160
V1 /VIN 0 DC {VSOURCE}
R2 0 /FB {RREF}
I1 /VOUT 0 DC {ILOAD}
R1 /FB /VOUT {RADJ}
Q1 0 /VK /VOUT DI_BC807-25
XU3 /VK 0 C2012X7R1H474K125AB_p
.end
