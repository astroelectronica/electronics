.title KiCad schematic
.include max4766c.lib
.model SWCTRL SW(Ron=1 Roff=1Meg Vt=.5 Vh=0)
R1 VCC /FLAG {RPU}
V42 /ON 0 PULSE( 0 3.3 5000m 50n 50n 15000m 20000m )
V1 VCC 0 DC {VSOURCE}
XU1 /SETB /FLAG /SETI /OUT VCC /SETS /ON 0 MAX4766C
C3 /OUT 0 {COUT}
R3 /OUT 0 {RLOAD1}
S1 /OUT /LOAD2 /CTRL 0 SWCTRL
R4 /LOAD2 0 {RLOAD2}
V43 /CTRL 0 PULSE( 0 5 10000m 50n 50n 5000m 20000m )
C2 /SETB 0 {CSETB}
R2 /SETI 0 {RSETI}
C1 /SETS 0 {CSETS}
.end
