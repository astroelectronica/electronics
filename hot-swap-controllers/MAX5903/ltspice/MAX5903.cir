.title KiCad schematic
.include "C:/Users/NachoDominguez-DETNO/Downloads/MAX5903/DMP10H088SPS.spice.txt"
.include "C:/Users/NachoDominguez-DETNO/Downloads/MAX5903/max5903a.lib"
.include "C:/Users/NachoDominguez-DETNO/Downloads/MAX5903/max5903l.lib"
.model SWCTRL_L SW(Ron=1 Roff=1Meg Vt=.5 Vh=0)
.model SWCTRL_A SW(Ron=1 Roff=1Meg Vt=.5 Vh=0)
R3 /VS_L /ONOFF_L {RON_L}
V4 /CTRL_L 0 PULSE( 0 5 1000m 500n 500n 3000m 4000m 1 )
S1 /VS_L VCC /CTRL_L 0 SWCTRL_L
S2 /VS_A VEE /CTRL_A 0 SWCTRL_A
V5 /CTRL_A 0 PULSE( 0 5 1000m 500n 500n 3000m 4000m 1 )
R1 VDD /PGOOD_L {RPU_L}
R4 /DRAIN_L 0 {RLOAD_L}
XU1 /VS_L /DRAIN_L /GATE_L 0 /PGOOD_L /ONOFF_L MAX5903L
XU2 /DRAIN_L /GATE_L /VS_L DMP10H088SPS
XU4 /DRAIN_A /GATE_A /VS_A DMP10H088SPS
R6 /DRAIN_A 0 {RLOAD_A}
C4 /DRAIN_A 0 {CLOAD_A}
XU3 /VS_A /DRAIN_A /GATE_A 0 /PGOOD_A /ONOFF_A MAX5903A
R2 VDD /PGOOD_A {RPU_A}
C1 /DRAIN_L 0 {CLOAD_L}
R5 /VS_A /ONOFF_A {RON_A}
V3 VDD 0 DC {VLOGIC}
V2 VCC 0 DC {VSOURCE_L}
V6 VEE 0 DC {VSOURCE_A}
.end
