.title KiCad schematic
.include DMN6017SK3.spice.txt
.include ZXGD3111N7.spice.txt
V2 VDDA VPP DC {VSUPPLY_A}
C1 VDDA VPP 10u
I1 VCC 0 DC {ILOAD}
XU2 VEE VEE VDDF /GB VEE VEE VCC ZXGD3111
C2 VDDF VEE 10u
V4 VDDF VEE DC {VSUPPLY_B}
V3 VEE 0 DC {VPSU_B}
XU3 VCC /GA VPP DMN6017SK3
V1 VPP 0 DC {VPSU_A}
XU1 VPP VPP VDDA /GA VPP VPP VCC ZXGD3111
XU4 VCC /GB VEE DMN6017SK3
.end
