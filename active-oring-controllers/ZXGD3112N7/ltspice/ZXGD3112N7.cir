.title KiCad schematic
.include DMN6017SK3.spice.txt
.include ZXGD3112N7.spice.txt
C1 VDDA VPP 10u
I1 VCC 0 DC {ILOAD}
V2 VDDA VPP DC {VSUPPLY_A}
V1 VPP 0 DC {VPSU_A}
XU3 VCC /GA VPP DMN6017SK3
XU1 VPP VPP VDDA /GA VPP VPP VCC ZXGD3112
XU2 VEE VEE VDDF /GB VEE VEE VCC ZXGD3112
XU4 VCC /GB VEE DMN6017SK3
V3 VEE 0 DC {VPSU_B}
C2 VDDF VEE 10u
V4 VDDF VEE DC {VSUPPLY_B}
.end
