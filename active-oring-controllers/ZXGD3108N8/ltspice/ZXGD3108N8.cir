.title KiCad schematic
.include DMN6017SK3.spice.txt
.include ZXGD3108N8.spice.txt
I1 VCC 0 DC {ILOAD}
C1 VDDA VPP 10u
V2 VDDA VPP DC {VSUPPLY_A}
V3 VEE 0 DC {VPSU_B}
C2 VDDF VEE 10u
V4 VDDF VEE DC {VSUPPLY_B}
XU2 unconnected-_U2-NC-Pad1_ VEE VEE /GB VDDF VDDF unconnected-_U2-NC-Pad7_ VCC ZXGD3108
V1 VPP 0 DC {VPSU_A}
XU1 unconnected-_U1-NC-Pad1_ VPP VPP /GA VDDA VDDA unconnected-_U1-NC-Pad7_ VCC ZXGD3108
XU4 VCC /GB VEE DMN6017SK3
XU3 VCC /GA VPP DMN6017SK3
.end
