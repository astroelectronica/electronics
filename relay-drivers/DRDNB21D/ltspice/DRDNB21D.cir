.title KiCad schematic
.include "DRDNB21D.spice.txt"
R1 /CTRL /B {RB}
Q1 /C /B 0 DI_DRDNB21D_NPN
L1 VCC /C {L_COIL} RSER={R_COIL}
V1 /CTRL 0 PULSE(0 {VCTRL} {TDELAY} {TR} {TF} {TDUTY} {TCYCLE})
D1 /C VCC DI_DRDNB21D_DIODE
R2 /B 0 {RPD}
V2 VCC 0 DC {VSOURCE} rser=50
.end
