.title KiCad schematic
.include TLV76701_TRANS.lib
.include c2012np02a102j060aa_p.mod
.include c2012x7r2a225k125ac_p.mod
V1 VCC 0 DC {VSOURCE}
XU1 VCC /FB 0 VCC VDD TLV76701_TRANS
XU2 VCC 0 C2012X7R2A225K125AC_p
R1 VDD /FB {RADJ}
R2 /FB 0 {RREF}
XU3 VDD 0 C2012X7R2A225K125AC_p
I1 VDD 0 DC {ILOAD}
XU4 VDD /FB C2012NP02A102J060AA_p
.end
